***************************
** nfet_03v3_t_id
***************************
* Copyright 2022 Efabless Corporation
*
* Licensed under the Apache License, Version 2.0 (the "License");
* you may not use this file except in compliance with the License.
* You may obtain a copy of the License at
*
*      http://www.apache.org/licenses/LICENSE-2.0
*
* Unless required by applicable law or agreed to in writing, software
* distributed under the License is distributed on an "AS IS" BASIS,
* WITHOUT WARRANTIES OR CONDITIONS OF ANY KIND, either express or implied.
* See the License for the specific language governing permissions and
* limitations under the License.

** library calling

.include "../../../design.ngspice"
.lib "../../../sm141064.ngspice" typical

** Circuit Description **
* power supply
vds D_tn 0 dc=3.3
vgs G_tn 0 dc={{vgs2}}

.temp {{temp}}
.options tnom={{temp}}

* circuit
mn D_tn G_tn 0 0 {{device}} W = {{width}}u L = {{length}}u

.control
set filetype=ascii
set wr_singlescale
set wr_vecnames

compose  vgs_vector   start={{vgs1}}          stop={{vgs2}}          step={{vgs3}}

set appendwrite

foreach t {{temp}}

    let vgs_counter = 0
    while vgs_counter < length(vgs_vector)
        option TEMP=$t
        alter vgs = vgs_vector[vgs_counter]

        save @mn[vgs] @mn[gds]
        *******************
        ** simulation part
        *******************
        DC vds {{vds}}

        * ** parameters calculation
        let Rds = 1/@mn[gds]
        let Vg = @mn[vgs]
        print @mn[gds]
        wrdata mos_iv_regr/{{device}}/{{device}}_netlists_Rds/T{{temp}}_simulated_W{{width}}_L{{length}}.csv Rds Vg
        reset
        let vgs_counter = vgs_counter + 1
    end
end
.endc
.end
